** sch_path: /home/designer/shared/unicass_2026/Design_Files/github_clone_circuit_/UNI-CASS_Project_2025_IIT_DH/digital_pulse_ina.sch
.subckt digital_pulse_ina

V5 VDD GND 1.6
V8 VCM_REF GND dc 0.6
V9 VICM_REF GND dc 0.8
I1 bv GND 1u
x1 PHI1 vinp PHI2 vinm PHI3 vop PHI4 vom gnd bv VICM_REF VCM_REF VDD imp_boost_tech
V6 vinp GND sin(0.8 5m 10000)
V7 vinm GND dc 0.8
x2 clk vdd gnd phi1 phi2 phi3 phi4 pulse_gen_circuit
V1 clk gnd pulse(0 1.6 0 10n 10n 99.99u 200u)
**** begin user architecture code

.lib cornerMOSlv.lib mos_tt
.lib cornerMOShv.lib mos_tt
.lib cornerHBT.lib hbt_typ
.lib cornerRES.lib res_typ
.lib cornerCAP.lib cap_typ

.option cshunt=2.5e-15
.tran 1u 5m
.control
run
plot v(PHI1) v(PHI2) v(PHI3) v(PHI4)
plot  v(vop,vom)
.endc

**** end user architecture code
.ends

* expanding   symbol:
*+  /home/designer/shared/unicass_2026/Design_Files/github_clone_circuit_/UNI-CASS_Project_2025_IIT_DH/imp_boost_tech.sym # of pins=13
** sym_path: /home/designer/shared/unicass_2026/Design_Files/github_clone_circuit_/UNI-CASS_Project_2025_IIT_DH/imp_boost_tech.sym
** sch_path: /home/designer/shared/unicass_2026/Design_Files/github_clone_circuit_/UNI-CASS_Project_2025_IIT_DH/imp_boost_tech.sch
.subckt imp_boost_tech phi1 vinp phi2 vinm phi3 vop phi4 vom gnd bv VICM_REF VCM_REF vdd
*.PININFO vinp:B vinm:B vop:B vom:B phi1:B phi2:B phi3:B phi4:B VICM_REF:B bv:B gnd:B vdd:B VCM_REF:B
XC3 net6 net5 cap_cmim w=26e-6 l=12.8e-6 m=1
XC4 net5 net6 cap_cmim w=26e-6 l=12.8e-6 m=1
XC5 net3 net4 cap_cmim w=26e-6 l=12.8e-6 m=1
XC6 net4 net3 cap_cmim w=26e-6 l=12.8e-6 m=1
XC7 net10 net9 cap_cmim w=5.7e-6 l=5.7e-6 m=1
XC8 net9 net10 cap_cmim w=5.7e-6 l=5.7e-6 m=1
XC9 net7 net8 cap_cmim w=5.7e-6 l=5.7e-6 m=1
XC10 net8 net7 cap_cmim w=5.7e-6 l=5.7e-6 m=1
x8 phi1 net1 vinp phi2 net2 vinm gnd CHOPPER
x1 phi3 net5 net1 phi4 net4 net2 gnd CHOPPER
x3 phi3 ota_vinp net6 phi4 ota_vinm net3 gnd CHOPPER
x4 phi1 net9 ota_vinp phi2 net8 ota_vinm gnd CHOPPER
x5 phi1 ota_vop net10 phi2 ota_vom net7 gnd CHOPPER
x6 phi1 vom ota_vop phi2 vop ota_vom gnd CHOPPER
x7 vdd VCM_REF ota_vop ota_vom gnd bv ota_vinm ota_vinp VICM_REF Differntial_ended_symbol_making
XC1 vom gnd cap_cmim w=7.0e-6 l=7.0e-6 m=1
XC2 vop gnd cap_cmim w=7.0e-6 l=7.0e-6 m=1
.ends

* expanding   symbol:
*+  /home/designer/shared/unicass_2026/Design_Files/github_clone_circuit_/UNI-CASS_Project_2025_IIT_DH/Clock_gen_using_transistor_hv/pulse_gen_circuit.sym # of pins=7
** sym_path: /home/designer/shared/unicass_2026/Design_Files/github_clone_circuit_/UNI-CASS_Project_2025_IIT_DH/Clock_gen_using_transistor_hv/pulse_gen_circuit.sym
** sch_path: /home/designer/shared/unicass_2026/Design_Files/github_clone_circuit_/UNI-CASS_Project_2025_IIT_DH/Clock_gen_using_transistor_hv/pulse_gen_circuit.sch
.subckt pulse_gen_circuit clk vdd gnd phi1 phi2 phi3 phi4
*.PININFO vdd:B gnd:B phi1:B phi2:B phi3:B phi4:B clk:B
x1 vdd x out1 gnd phi3 and
x2 vdd y net1 gnd phi4 and
x4 vdd phi2 clk gnd x nor
x6 vdd clk_bar phi1 gnd y nor
x7 clk clk_bar vdd gnd inverter
x8 phi1 out1 vdd gnd buffer
x9 phi2 net1 vdd gnd buffer
x3 x phi1 vdd gnd buffer
x5 y phi2 vdd gnd buffer
.ends

* expanding   symbol:
*+  /home/designer/shared/unicass_2026/Design_Files/github_clone_circuit_/UNI-CASS_Project_2025_IIT_DH/CHOPPER.sym # of pins=7
** sym_path: /home/designer/shared/unicass_2026/Design_Files/github_clone_circuit_/UNI-CASS_Project_2025_IIT_DH/CHOPPER.sym
** sch_path: /home/designer/shared/unicass_2026/Design_Files/github_clone_circuit_/UNI-CASS_Project_2025_IIT_DH/CHOPPER.sch
.subckt CHOPPER PHIA OUT_A IN_A PHIB OUT_B IN_B GND
*.PININFO IN_A:B IN_B:B OUT_B:B OUT_A:B PHIA:B PHIB:B GND:B
XM1 OUT_A PHIA IN_A GND sg13_hv_nmos w=0.3u l=0.45u ng=1 m=1
XM2 OUT_B PHIA IN_B GND sg13_hv_nmos w=0.3u l=0.45u ng=1 m=1
XM3 OUT_B PHIB IN_A GND sg13_hv_nmos w=0.3u l=0.45u ng=1 m=1
XM4 IN_B PHIB OUT_A GND sg13_hv_nmos w=0.3u l=0.45u ng=1 m=1
.ends

* expanding   symbol:
*+  /home/designer/shared/unicass_2026/Design_Files/github_clone_circuit_/UNI-CASS_Project_2025_IIT_DH/Differntial_ended_symbol_making.sym # of pins=9
** sym_path: /home/designer/shared/unicass_2026/Design_Files/github_clone_circuit_/UNI-CASS_Project_2025_IIT_DH/Differntial_ended_symbol_making.sym
** sch_path: /home/designer/shared/unicass_2026/Design_Files/github_clone_circuit_/UNI-CASS_Project_2025_IIT_DH/Differntial_ended_symbol_making.sch
.subckt Differntial_ended_symbol_making vdd vcm_ref vom vop gnd b_v vinm vinp VICM_REF
*.PININFO b_v:B vinm:B vcm_ref:B vinp:B vop:B vom:B gnd:B vdd:B VICM_REF:B
XM7 vop nbias gnd gnd sg13_hv_nmos w=2u l=2u ng=1 m=2
XM8 vop vinm tail vdd sg13_hv_pmos w=4.5u l=1u ng=1 m=2
XM9 vom nbias gnd gnd sg13_hv_nmos w=2u l=2u ng=1 m=2
XM10 vom vinp tail vdd sg13_hv_pmos w=4.5u l=1u ng=1 m=2
XM11 tail b_v vdd vdd sg13_hv_pmos w=4u l=1u ng=1 m=4
XM6 net1 net1 gnd gnd sg13_hv_nmos w=1u l=0.5u ng=1 m=1
XM13 net1 vop tail_cmfb vdd sg13_hv_pmos w=2.25u l=0.50u ng=1 m=1
XM14 nbias net1 gnd gnd sg13_hv_nmos w=1u l=0.5u ng=1 m=1
XM15 nbias vcm_ref tail_cmfb vdd sg13_hv_pmos w=2.25u l=0.5u ng=1 m=2
XM16 tail_cmfb b_v vdd vdd sg13_hv_pmos w=4u l=1u ng=1 m=4
XM17 net1 vom tail_cmfb vdd sg13_hv_pmos w=2.25u l=0.50u ng=1 m=1
XM1 b_v b_v vdd vdd sg13_hv_pmos w=4u l=1u ng=1 m=1
XC1 nbias gnd cap_cmim w=14.0e-6 l=50.0e-6 m=1
XM2 VICM_REF vinm vinm vdd sg13_hv_pmos w=50u l=1u ng=5 m=1
XM3 VICM_REF vinp vinp vdd sg13_hv_pmos w=50u l=1u ng=5 m=1
XM4 vdd vdd vdd vdd sg13_hv_pmos w=4.5u l=0.4u ng=1 m=4
XM5 gnd gnd gnd gnd sg13_hv_nmos w=2u l=2u ng=1 m=4
.ends

* expanding   symbol:
*+  /home/designer/shared/unicass_2026/Design_Files/github_clone_circuit_/UNI-CASS_Project_2025_IIT_DH/Clock_gen_using_transistor_hv/and.sym # of pins=5
** sym_path: /home/designer/shared/unicass_2026/Design_Files/github_clone_circuit_/UNI-CASS_Project_2025_IIT_DH/Clock_gen_using_transistor_hv/and.sym
** sch_path: /home/designer/shared/unicass_2026/Design_Files/github_clone_circuit_/UNI-CASS_Project_2025_IIT_DH/Clock_gen_using_transistor_hv/and.sch
.subckt and vdd B A gnd out
*.PININFO vdd:B B:B A:B gnd:B out:B
XM3 net1 A vdd vdd sg13_hv_pmos w=0.3u l=0.45u ng=1 m=1
XM1 net2 B gnd gnd sg13_hv_nmos w=0.3u l=0.45u ng=1 m=1
XM2 net1 A net2 gnd sg13_hv_nmos w=0.3u l=0.45u ng=1 m=1
XM4 net1 B vdd vdd sg13_hv_pmos w=0.3u l=0.45u ng=1 m=1
XM5 out net1 vdd vdd sg13_hv_pmos w=0.6u l=0.9u ng=1 m=1
XM6 out net1 gnd gnd sg13_hv_nmos w=0.3u l=0.45u ng=1 m=1
.ends

* expanding   symbol:
*+  /home/designer/shared/unicass_2026/Design_Files/github_clone_circuit_/UNI-CASS_Project_2025_IIT_DH/Clock_gen_using_transistor_hv/nor.sym # of pins=5
** sym_path: /home/designer/shared/unicass_2026/Design_Files/github_clone_circuit_/UNI-CASS_Project_2025_IIT_DH/Clock_gen_using_transistor_hv/nor.sym
** sch_path: /home/designer/shared/unicass_2026/Design_Files/github_clone_circuit_/UNI-CASS_Project_2025_IIT_DH/Clock_gen_using_transistor_hv/nor.sch
.subckt nor vdd B A gnd out
*.PININFO vdd:B B:B A:B gnd:B out:B
XM3 net1 A vdd vdd sg13_hv_pmos w=1.2u l=1.8u ng=1 m=1
XM1 out B gnd gnd sg13_hv_nmos w=0.3u l=0.45u ng=1 m=1
XM2 out A gnd gnd sg13_hv_nmos w=0.3u l=0.45u ng=1 m=1
XM4 out B net1 vdd sg13_hv_pmos w=1.2u l=1.8u ng=1 m=1
.ends

* expanding   symbol:
*+  /home/designer/shared/unicass_2026/Design_Files/github_clone_circuit_/UNI-CASS_Project_2025_IIT_DH/Clock_gen_using_transistor_hv/inverter.sym # of pins=4
** sym_path: /home/designer/shared/unicass_2026/Design_Files/github_clone_circuit_/UNI-CASS_Project_2025_IIT_DH/Clock_gen_using_transistor_hv/inverter.sym
** sch_path: /home/designer/shared/unicass_2026/Design_Files/github_clone_circuit_/UNI-CASS_Project_2025_IIT_DH/Clock_gen_using_transistor_hv/inverter.sch
.subckt inverter in out vdd gnd
*.PININFO in:B vdd:B out:B gnd:B
XM3 out in vdd vdd sg13_hv_pmos w=0.6u l=0.9u ng=1 m=1
XM1 out in gnd gnd sg13_hv_nmos w=0.3u l=0.45u ng=1 m=1
.ends

* expanding   symbol:
*+  /home/designer/shared/unicass_2026/Design_Files/github_clone_circuit_/UNI-CASS_Project_2025_IIT_DH/Clock_gen_using_transistor_hv/buffer.sym # of pins=4
** sym_path: /home/designer/shared/unicass_2026/Design_Files/github_clone_circuit_/UNI-CASS_Project_2025_IIT_DH/Clock_gen_using_transistor_hv/buffer.sym
** sch_path: /home/designer/shared/unicass_2026/Design_Files/github_clone_circuit_/UNI-CASS_Project_2025_IIT_DH/Clock_gen_using_transistor_hv/buffer.sch
.subckt buffer in out vdd gnd
*.PININFO in:B out:B vdd:B gnd:B
x1 in net1 vdd gnd inverter
x2 net1 net2 vdd gnd inverter
x3 net2 net3 vdd gnd inverter
x4 net3 out vdd gnd inverter
XC1 net1 gnd net4 cap_rfcmim w=7.0e-6 l=7.0e-6 wfeed=5.0e-6
.ends

.GLOBAL GND
.GLOBAL gnd
