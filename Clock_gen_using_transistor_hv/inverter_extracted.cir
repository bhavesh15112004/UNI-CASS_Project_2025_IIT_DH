* Extracted by KLayout with SG13G2 LVS runset on : 11/03/2026 14:46

.SUBCKT inverter VDD gnd IN OUT
M$1 OUT IN gnd gnd sg13_hv_nmos L=0.45u W=0.3u AS=0.102p AD=0.102p PS=1.28u
+ PD=1.28u
M$2 VDD IN OUT VDD sg13_hv_pmos L=0.9u W=0.6u AS=0.204p AD=0.204p PS=1.88u
+ PD=1.88u
.ENDS inverter
