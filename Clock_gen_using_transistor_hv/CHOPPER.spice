** sch_path: /home/designer/shared/unicass_2026/Design_Files/UNI-CASS_Project_2025_IIT_DH/CHOPPER.sch
.subckt CHOPPER PHIA OUT_A IN_A PHIB OUT_B IN_B SUB
*.PININFO IN_A:B IN_B:B OUT_B:B OUT_A:B PHIA:B PHIB:B SUB:B
XM1 OUT_A PHIA IN_A SUB sg13_hv_nmos w=0.3u l=0.45u ng=1 m=1
XM2 OUT_B PHIA IN_B SUB sg13_hv_nmos w=0.3u l=0.45u ng=1 m=1
XM3 OUT_B PHIB IN_A SUB sg13_hv_nmos w=0.3u l=0.45u ng=1 m=1
XM4 IN_B PHIB OUT_A SUB sg13_hv_nmos w=0.3u l=0.45u ng=1 m=1
.ends
