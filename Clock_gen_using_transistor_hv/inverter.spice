** sch_path: /home/designer/shared/unicass_2026/Design_Files/github_clone_circuit_/UNI-CASS_Project_2025_IIT_DH/Clock_gen_using_transistor_hv/inverter.sch
.subckt inverter in out vdd gnd
*.PININFO in:B vdd:B out:B gnd:B
M3 out in vdd vdd sg13_hv_pmos w=0.6u l=0.9u ng=1 m=1
M1 out in gnd gnd sg13_hv_nmos w=0.3u l=0.45u ng=1 m=1
.ends
