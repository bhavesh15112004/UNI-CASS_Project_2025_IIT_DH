** sch_path: /home/designer/shared/unicass_2026/Design_Files/github_clone_circuit_/UNI-CASS_Project_2025_IIT_DH/tb_INA.sch
.subckt tb_INA

V1 PHI1 GND pulse(0 1.6 {delay_phi1} 10p 10p {width} {Tch})
V2 PHI2 GND pulse(0 1.6 {delay_phi2} 10p 10p {width} {Tch})
V3 PHI3 GND pulse(0 1.6 {delay_phi1+1u} 10p 10p {width-2u} {Tch})
V4 PHI4 GND pulse(0 1.6 {delay_phi2+1u} 10p 10p {width-2u} {Tch})
V5 VDD GND 1.6
V8 VCM_REF GND dc 0.6
V9 VICM_REF GND dc 0.8
I1 bv GND 1u
x1 PHI1 vinp PHI2 vinm PHI3 vop PHI4 vom GND bv VICM_REF VCM_REF VDD imp_boost_tech
V6 vinp GND sin(0.8 5m {Fin})
V7 vinm GND dc 0.8
**** begin user architecture code

.param Tch=10u Fin=1k
.param delay_phi1=0 delay_phi2={Tch/2} width={Tch/2-0.5u}
*.op
.tran 10u {4/Fin} {2/Fin}
.control
run
plot v(PHI1) v(PHI2)v(PHI3) v(PHI4)
plot  v(vop,vom)
.endc

.lib cornerMOSlv.lib mos_tt
.lib cornerMOShv.lib mos_tt
.lib cornerHBT.lib hbt_typ
.lib cornerRES.lib res_typ
.lib cornerCAP.lib cap_typ

**** end user architecture code
.ends

* expanding   symbol:  /home/designer/shared/unicass_2026/Design_Files/UNI-CASS_Project_2025_IIT_DH/imp_boost_tech.sym # of
*+ pins=13
** sym_path: /home/designer/shared/unicass_2026/Design_Files/UNI-CASS_Project_2025_IIT_DH/imp_boost_tech.sym
** sch_path: /home/designer/shared/unicass_2026/Design_Files/UNI-CASS_Project_2025_IIT_DH/imp_boost_tech.sch
.subckt imp_boost_tech phi1 vinp phi2 vinm phi3 vop phi4 vom gnd bv VICM_REF VCM_REF vdd
*.PININFO vinp:B vinm:B vop:B vom:B phi1:B phi2:B phi3:B phi4:B VICM_REF:B bv:B gnd:B vdd:B VCM_REF:B
XC3 net2 ch2_b cap_cmim w=12.8e-6 l=12.8e-6 m=2
XC4 ch2_b net2 cap_cmim w=12.8e-6 l=12.8e-6 m=2
XC5 net1 ch2_a cap_cmim w=12.8e-6 l=12.8e-6 m=2
XC6 ch2_a net1 cap_cmim w=12.8e-6 l=12.8e-6 m=2
XC7 net6 net5 cap_cmim w=5.7e-6 l=5.7e-6 m=1
XC8 net5 net6 cap_cmim w=5.7e-6 l=5.7e-6 m=1
XC9 net3 net4 cap_cmim w=5.7e-6 l=5.7e-6 m=1
XC10 net4 net3 cap_cmim w=5.7e-6 l=5.7e-6 m=1
XC1 vop gnd cap_cmim w=7e-6 l=7e-6 m=14
XC2 vom gnd cap_cmim w=7e-6 l=7e-6 m=14
x8 phi1 ch1_b vinp phi2 ch1_a vinm gnd CHOPPER
x1 phi3 ch2_b ch1_b phi4 ch2_a ch1_a gnd CHOPPER
x3 phi3 ota_vinp net2 phi4 ota_vinm net1 gnd CHOPPER
x4 phi1 net5 ota_vinp phi2 net4 ota_vinm gnd CHOPPER
x5 phi1 ota_vop net6 phi2 ota_vom net3 gnd CHOPPER
x6 phi1 vop ota_vop phi2 vom ota_vom gnd CHOPPER
x7 vdd VCM_REF ota_vop ota_vom gnd bv ota_vinm ota_vinp VICM_REF Differntial_ended_symbol_making
.ends

* expanding   symbol:  /home/designer/shared/unicass_2026/Design_Files/UNI-CASS_Project_2025_IIT_DH/CHOPPER.sym # of pins=7
** sym_path: /home/designer/shared/unicass_2026/Design_Files/UNI-CASS_Project_2025_IIT_DH/CHOPPER.sym
** sch_path: /home/designer/shared/unicass_2026/Design_Files/UNI-CASS_Project_2025_IIT_DH/CHOPPER.sch
.subckt CHOPPER PHIA OUT_A IN_A PHIB OUT_B IN_B sub!
*.PININFO IN_A:B IN_B:B OUT_B:B OUT_A:B PHIA:B PHIB:B sub!:B
XM1 OUT_A PHIA IN_A sub! sg13_hv_nmos w=0.3u l=0.45u ng=1 m=1
XM2 OUT_B PHIA IN_B sub! sg13_hv_nmos w=0.3u l=0.45u ng=1 m=1
XM3 OUT_B PHIB IN_A sub! sg13_hv_nmos w=0.3u l=0.45u ng=1 m=1
XM4 IN_B PHIB OUT_A sub! sg13_hv_nmos w=0.3u l=0.45u ng=1 m=1
.ends

* expanding   symbol:
*+  /home/designer/shared/unicass_2026/Design_Files/UNI-CASS_Project_2025_IIT_DH/Differntial_ended_symbol_making.sym # of pins=9
** sym_path: /home/designer/shared/unicass_2026/Design_Files/UNI-CASS_Project_2025_IIT_DH/Differntial_ended_symbol_making.sym
** sch_path: /home/designer/shared/unicass_2026/Design_Files/UNI-CASS_Project_2025_IIT_DH/Differntial_ended_symbol_making.sch
.subckt Differntial_ended_symbol_making vdd vcm_ref vom vop gnd b_v vinm vinp VICM_REF
*.PININFO b_v:B vinm:B vcm_ref:B vinp:B vop:B vom:B gnd:B vdd:B VICM_REF:B
XM7 vop nbias gnd gnd sg13_hv_nmos w=4u l=2u ng=1 m=1
XM8 vop vinm tail tail sg13_hv_pmos w=4.5u l=1u ng=1 m=2
XM9 vom nbias gnd gnd sg13_hv_nmos w=4u l=2u ng=1 m=1
XM10 vom vinp tail tail sg13_hv_pmos w=4.5u l=1u ng=1 m=2
XM11 tail b_v vdd vdd sg13_hv_pmos w=4u l=1u ng=1 m=4
XM6 net1 net1 gnd gnd sg13_hv_nmos w=1u l=0.5u ng=1 m=1
XM13 net1 vop tail_cmfb tail_cmfb sg13_hv_pmos w=2.25u l=0.50u ng=1 m=1
XM14 nbias net1 gnd gnd sg13_hv_nmos w=1u l=0.5u ng=1 m=1
XM15 nbias vcm_ref tail_cmfb tail_cmfb sg13_hv_pmos w=4.5u l=0.5u ng=1 m=1
XM16 tail_cmfb b_v vdd vdd sg13_hv_pmos w=4u l=1u ng=1 m=4
XM17 net1 vom tail_cmfb tail_cmfb sg13_hv_pmos w=2.25u l=0.50u ng=1 m=1
XM1 b_v b_v vdd vdd sg13_hv_pmos w=4u l=1u ng=1 m=1
XC1 nbias gnd cap_cmim w=14.0e-6 l=50.0e-6 m=1
XM2 VICM_REF vinm vinm vinm sg13_hv_pmos w=50u l=1u ng=5 m=1
XM3 VICM_REF vinp vinp vinp sg13_hv_pmos w=50u l=1u ng=5 m=1
.ends

.GLOBAL GND
.GLOBAL sub!
