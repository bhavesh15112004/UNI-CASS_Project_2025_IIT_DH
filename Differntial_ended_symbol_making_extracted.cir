* Extracted by KLayout with SG13G2 LVS runset on : 06/03/2026 09:46

.SUBCKT Differntial_ended_symbol_making GND vop vinp vinm VDD VCM_REF VICM_REF
+ BV
M$1 GND GND GND GND sg13_hv_nmos L=2u W=8u AS=2.72p AD=2.72p PS=18.72u PD=18.72u
M$2 vop \$2 GND GND sg13_hv_nmos L=2u W=4u AS=1.36p AD=1.36p PS=9.36u PD=9.36u
M$3 GND \$2 \$4 GND sg13_hv_nmos L=2u W=4u AS=1.36p AD=1.36p PS=9.36u PD=9.36u
M$9 \$17 \$17 GND GND sg13_hv_nmos L=0.5u W=1u AS=0.34p AD=0.34p PS=2.68u
+ PD=2.68u
M$10 GND \$17 \$2 GND sg13_hv_nmos L=0.5u W=1u AS=0.34p AD=0.34p PS=2.68u
+ PD=2.68u
M$11 VDD VDD VDD VDD sg13_hv_pmos L=0.4u W=18u AS=6.12p AD=6.12p PS=38.72u
+ PD=38.72u
M$12 \$4 vinp \$16 VDD sg13_hv_pmos L=1u W=9u AS=3.06p AD=3.06p PS=19.36u
+ PD=19.36u
M$13 \$16 vinm vop VDD sg13_hv_pmos L=1u W=9u AS=3.06p AD=3.06p PS=19.36u
+ PD=19.36u
M$15 \$24 VCM_REF \$2 VDD sg13_hv_pmos L=0.5u W=4.5u AS=1.53p AD=1.53p
+ PS=10.36u PD=10.36u
M$17 \$24 vop \$17 VDD sg13_hv_pmos L=0.5u W=2.25u AS=0.765p AD=0.765p PS=5.18u
+ PD=5.18u
M$18 \$17 \$4 \$24 VDD sg13_hv_pmos L=0.5u W=2.25u AS=0.765p AD=0.765p PS=5.18u
+ PD=5.18u
M$23 \$16 BV VDD VDD sg13_hv_pmos L=1u W=16u AS=5.44p AD=5.44p PS=34.72u
+ PD=34.72u
M$27 VICM_REF vinm vinm VDD sg13_hv_pmos L=1u W=50u AS=11p AD=11p PS=62.2u
+ PD=62.2u
M$32 vinp vinp VICM_REF VDD sg13_hv_pmos L=1u W=50u AS=11p AD=11p PS=62.2u
+ PD=62.2u
M$37 \$24 BV VDD VDD sg13_hv_pmos L=1u W=16u AS=5.44p AD=5.44p PS=34.72u
+ PD=34.72u
M$41 BV BV VDD VDD sg13_hv_pmos L=1u W=4u AS=1.36p AD=1.36p PS=8.68u PD=8.68u
C$42 \$2 GND cap_cmim w=50u l=14u A=700p P=128u m=1
.ENDS Differntial_ended_symbol_making
