* Extracted by KLayout with SG13G2 LVS runset on : 13/03/2026 07:18

.SUBCKT Differntial_ended_symbol_making VDD VCM_REF VICM_REF BV
M$1 \$1 \$1 \$1 \$1 sg13_hv_nmos L=2u W=8u AS=2.72p AD=2.72p PS=18.72u PD=18.72u
M$2 \$3 \$2 \$1 \$1 sg13_hv_nmos L=2u W=4u AS=1.36p AD=1.36p PS=9.36u PD=9.36u
M$3 \$1 \$2 \$4 \$1 sg13_hv_nmos L=2u W=4u AS=1.36p AD=1.36p PS=9.36u PD=9.36u
M$9 \$16 \$16 \$1 \$1 sg13_hv_nmos L=0.5u W=1u AS=0.34p AD=0.34p PS=2.68u
+ PD=2.68u
M$10 \$1 \$16 \$2 \$1 sg13_hv_nmos L=0.5u W=1u AS=0.34p AD=0.34p PS=2.68u
+ PD=2.68u
M$11 VDD VDD VDD VDD sg13_hv_pmos L=0.4u W=18u AS=6.12p AD=6.12p PS=38.72u
+ PD=38.72u
M$12 \$4 \$13 \$15 VDD sg13_hv_pmos L=1u W=9u AS=3.06p AD=3.06p PS=19.36u
+ PD=19.36u
M$13 \$15 \$33 \$3 VDD sg13_hv_pmos L=1u W=9u AS=3.06p AD=3.06p PS=19.36u
+ PD=19.36u
M$15 \$23 VCM_REF \$2 VDD sg13_hv_pmos L=0.5u W=4.5u AS=1.53p AD=1.53p
+ PS=10.36u PD=10.36u
M$17 \$23 \$3 \$16 VDD sg13_hv_pmos L=0.5u W=2.25u AS=0.765p AD=0.765p PS=5.18u
+ PD=5.18u
M$18 \$16 \$4 \$23 VDD sg13_hv_pmos L=0.5u W=2.25u AS=0.765p AD=0.765p PS=5.18u
+ PD=5.18u
M$23 \$15 BV VDD VDD sg13_hv_pmos L=1u W=16u AS=5.44p AD=5.44p PS=34.72u
+ PD=34.72u
M$27 VICM_REF \$33 \$33 VDD sg13_hv_pmos L=1u W=50u AS=11p AD=11p PS=62.2u
+ PD=62.2u
M$32 \$13 \$13 VICM_REF VDD sg13_hv_pmos L=1u W=50u AS=11p AD=11p PS=62.2u
+ PD=62.2u
M$37 \$23 BV VDD VDD sg13_hv_pmos L=1u W=16u AS=5.44p AD=5.44p PS=34.72u
+ PD=34.72u
M$41 BV BV VDD VDD sg13_hv_pmos L=1u W=4u AS=1.36p AD=1.36p PS=8.68u PD=8.68u
C$42 \$2 \$1 cap_cmim w=50u l=14u A=700p P=128u m=1
.ENDS Differntial_ended_symbol_making
