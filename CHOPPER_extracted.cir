* Extracted by KLayout with SG13G2 LVS runset on : 12/03/2026 19:39

.SUBCKT CHOPPER GND PHIB PHIA OUT_B OUT_A IN_B IN_A
M$1 IN_A PHIB OUT_B GND sg13_hv_nmos L=0.45u W=0.3u AS=0.102p AD=0.102p
+ PS=1.28u PD=1.28u
M$2 IN_B PHIB OUT_A GND sg13_hv_nmos L=0.45u W=0.3u AS=0.102p AD=0.102p
+ PS=1.28u PD=1.28u
M$3 IN_A PHIA OUT_A GND sg13_hv_nmos L=0.45u W=0.3u AS=0.102p AD=0.102p
+ PS=1.28u PD=1.28u
M$4 IN_B PHIA OUT_B GND sg13_hv_nmos L=0.45u W=0.3u AS=0.102p AD=0.102p
+ PS=1.28u PD=1.28u
.ENDS CHOPPER
