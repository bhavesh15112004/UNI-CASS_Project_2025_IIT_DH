* Extracted by KLayout with SG13G2 LVS runset on : 04/03/2026 15:38

.SUBCKT CHOPPER GND PHIB PHIA OUT_A OUT_B IN_A IN_B
M$1 IN_B PHIB OUT_A GND sg13_hv_nmos L=0.45u W=0.3u AS=0.102p AD=0.102p
+ PS=1.28u PD=1.28u
M$2 IN_A PHIB OUT_B GND sg13_hv_nmos L=0.45u W=0.3u AS=0.102p AD=0.102p
+ PS=1.28u PD=1.28u
M$3 IN_B PHIA OUT_B GND sg13_hv_nmos L=0.45u W=0.3u AS=0.102p AD=0.102p
+ PS=1.28u PD=1.28u
M$4 IN_A PHIA OUT_A GND sg13_hv_nmos L=0.45u W=0.3u AS=0.102p AD=0.102p
+ PS=1.28u PD=1.28u
.ENDS CHOPPER
