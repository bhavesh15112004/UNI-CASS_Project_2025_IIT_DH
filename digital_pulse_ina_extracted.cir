* Extracted by KLayout with SG13G2 LVS runset on : 06/03/2026 13:21

.SUBCKT digital_pulse_ina
M$1 GND|gnd GND|gnd GND|gnd GND|gnd sg13_hv_nmos L=2u W=2u AS=0.68p AD=0.68p
+ PS=4.68u PD=4.68u
M$2 OTA_VOM \$3 GND|gnd GND|gnd sg13_hv_nmos L=2u W=2u AS=0.68p AD=0.68p
+ PS=4.68u PD=4.68u
M$3 GND|gnd \$3 OTA_VOP GND|gnd sg13_hv_nmos L=2u W=2u AS=0.68p AD=0.68p
+ PS=4.68u PD=4.68u
M$4 GND|gnd GND|gnd GND|gnd GND|gnd sg13_hv_nmos L=2u W=2u AS=0.68p AD=0.68p
+ PS=4.68u PD=4.68u
M$5 GND|gnd GND|gnd GND|gnd GND|gnd sg13_hv_nmos L=2u W=2u AS=0.68p AD=0.68p
+ PS=4.68u PD=4.68u
M$6 OTA_VOP \$3 GND|gnd GND|gnd sg13_hv_nmos L=2u W=2u AS=0.68p AD=0.68p
+ PS=4.68u PD=4.68u
M$7 GND|gnd \$3 OTA_VOM GND|gnd sg13_hv_nmos L=2u W=2u AS=0.68p AD=0.68p
+ PS=4.68u PD=4.68u
M$8 GND|gnd GND|gnd GND|gnd GND|gnd sg13_hv_nmos L=2u W=2u AS=0.68p AD=0.68p
+ PS=4.68u PD=4.68u
M$9 \$34 PHI2 \$55 GND|gnd sg13_hv_nmos L=0.45u W=0.3u AS=0.102p AD=0.102p
+ PS=1.28u PD=1.28u
M$10 \$58 PHI2 OTA_VOM GND|gnd sg13_hv_nmos L=0.45u W=0.3u AS=0.102p AD=0.102p
+ PS=1.28u PD=1.28u
M$11 \$17 \$17 GND|gnd GND|gnd sg13_hv_nmos L=0.5u W=1u AS=0.34p AD=0.34p
+ PS=2.68u PD=2.68u
M$12 GND|gnd \$17 \$3 GND|gnd sg13_hv_nmos L=0.5u W=1u AS=0.34p AD=0.34p
+ PS=2.68u PD=2.68u
M$13 \$67 PHI4 \$57 GND|gnd sg13_hv_nmos L=0.45u W=0.3u AS=0.102p AD=0.102p
+ PS=1.28u PD=1.28u
M$14 \$93 PHI4 \$14 GND|gnd sg13_hv_nmos L=0.45u W=0.3u AS=0.102p AD=0.102p
+ PS=1.28u PD=1.28u
M$15 VINM PHI2 \$56 GND|gnd sg13_hv_nmos L=0.45u W=0.3u AS=0.102p AD=0.102p
+ PS=1.28u PD=1.28u
M$16 \$14 PHI2 \$53 GND|gnd sg13_hv_nmos L=0.45u W=0.3u AS=0.102p AD=0.102p
+ PS=1.28u PD=1.28u
M$17 \$52 PHI2 OTA_VOP GND|gnd sg13_hv_nmos L=0.45u W=0.3u AS=0.102p AD=0.102p
+ PS=1.28u PD=1.28u
M$18 OTA_VOP PHI2 VOP GND|gnd sg13_hv_nmos L=0.45u W=0.3u AS=0.102p AD=0.102p
+ PS=1.28u PD=1.28u
M$19 \$56 PHI4 \$51 GND|gnd sg13_hv_nmos L=0.45u W=0.3u AS=0.102p AD=0.102p
+ PS=1.28u PD=1.28u
M$20 \$50 PHI4 \$34 GND|gnd sg13_hv_nmos L=0.45u W=0.3u AS=0.102p AD=0.102p
+ PS=1.28u PD=1.28u
M$21 VINP PHI2 \$67 GND|gnd sg13_hv_nmos L=0.45u W=0.3u AS=0.102p AD=0.102p
+ PS=1.28u PD=1.28u
M$22 \$34 PHI1 \$53 GND|gnd sg13_hv_nmos L=0.45u W=0.3u AS=0.102p AD=0.102p
+ PS=1.28u PD=1.28u
M$23 \$58 PHI1 OTA_VOP GND|gnd sg13_hv_nmos L=0.45u W=0.3u AS=0.102p AD=0.102p
+ PS=1.28u PD=1.28u
M$24 OTA_VOM PHI2 VOM GND|gnd sg13_hv_nmos L=0.45u W=0.3u AS=0.102p AD=0.102p
+ PS=1.28u PD=1.28u
M$25 \$67 PHI3 \$51 GND|gnd sg13_hv_nmos L=0.45u W=0.3u AS=0.102p AD=0.102p
+ PS=1.28u PD=1.28u
M$26 \$93 PHI3 \$34 GND|gnd sg13_hv_nmos L=0.45u W=0.3u AS=0.102p AD=0.102p
+ PS=1.28u PD=1.28u
M$27 VINM PHI1 \$67 GND|gnd sg13_hv_nmos L=0.45u W=0.3u AS=0.102p AD=0.102p
+ PS=1.28u PD=1.28u
M$28 \$14 PHI1 \$55 GND|gnd sg13_hv_nmos L=0.45u W=0.3u AS=0.102p AD=0.102p
+ PS=1.28u PD=1.28u
M$29 \$52 PHI1 OTA_VOM GND|gnd sg13_hv_nmos L=0.45u W=0.3u AS=0.102p AD=0.102p
+ PS=1.28u PD=1.28u
M$30 OTA_VOP PHI1 VOM GND|gnd sg13_hv_nmos L=0.45u W=0.3u AS=0.102p AD=0.102p
+ PS=1.28u PD=1.28u
M$31 \$56 PHI3 \$57 GND|gnd sg13_hv_nmos L=0.45u W=0.3u AS=0.102p AD=0.102p
+ PS=1.28u PD=1.28u
M$32 \$50 PHI3 \$14 GND|gnd sg13_hv_nmos L=0.45u W=0.3u AS=0.102p AD=0.102p
+ PS=1.28u PD=1.28u
M$33 VINP PHI1 \$56 GND|gnd sg13_hv_nmos L=0.45u W=0.3u AS=0.102p AD=0.102p
+ PS=1.28u PD=1.28u
M$34 GND|gnd B out GND|gnd sg13_hv_nmos L=0.45u W=0.3u AS=0.102p AD=0.102p
+ PS=1.28u PD=1.28u
M$35 out A GND|gnd GND|gnd sg13_hv_nmos L=0.45u W=0.3u AS=0.102p AD=0.102p
+ PS=1.28u PD=1.28u
M$36 OTA_VOM PHI1 VOP GND|gnd sg13_hv_nmos L=0.45u W=0.3u AS=0.102p AD=0.102p
+ PS=1.28u PD=1.28u
M$37 GND|gnd B$1 \$103 GND|gnd sg13_hv_nmos L=0.45u W=0.3u AS=0.102p AD=0.102p
+ PS=1.28u PD=1.28u
M$38 \$103 A$1 \$104 GND|gnd sg13_hv_nmos L=0.45u W=0.3u AS=0.102p AD=0.102p
+ PS=1.28u PD=1.28u
M$39 GND|gnd \$104 \$105 GND|gnd sg13_hv_nmos L=0.45u W=0.3u AS=0.102p
+ AD=0.102p PS=1.28u PD=1.28u
M$40 GND|gnd IN$1 IN|OUT GND|gnd sg13_hv_nmos L=0.45u W=0.3u AS=0.102p
+ AD=0.102p PS=1.28u PD=1.28u
M$41 GND|gnd IN|OUT IN|OUT$4 GND|gnd sg13_hv_nmos L=0.45u W=0.3u AS=0.102p
+ AD=0.102p PS=1.28u PD=1.28u
M$42 GND|gnd IN|OUT$5 OUT$1 GND|gnd sg13_hv_nmos L=0.45u W=0.3u AS=0.102p
+ AD=0.102p PS=1.28u PD=1.28u
M$43 GND|gnd IN IN|OUT$1 GND|gnd sg13_hv_nmos L=0.45u W=0.3u AS=0.102p
+ AD=0.102p PS=1.28u PD=1.28u
M$44 GND|gnd IN|OUT$3 OUT GND|gnd sg13_hv_nmos L=0.45u W=0.3u AS=0.102p
+ AD=0.102p PS=1.28u PD=1.28u
M$45 GND|gnd IN|OUT$4 IN|OUT$5 GND|gnd sg13_hv_nmos L=0.45u W=0.3u AS=0.102p
+ AD=0.102p PS=1.28u PD=1.28u
M$46 OUT$2 IN$2 GND|gnd GND|gnd sg13_hv_nmos L=0.45u W=0.3u AS=0.102p AD=0.102p
+ PS=1.28u PD=1.28u
M$47 GND|gnd B$2 out$1 GND|gnd sg13_hv_nmos L=0.45u W=0.3u AS=0.102p AD=0.102p
+ PS=1.28u PD=1.28u
M$48 out$1 A$2 GND|gnd GND|gnd sg13_hv_nmos L=0.45u W=0.3u AS=0.102p AD=0.102p
+ PS=1.28u PD=1.28u
M$49 GND|gnd IN|OUT$1 IN|OUT$2 GND|gnd sg13_hv_nmos L=0.45u W=0.3u AS=0.102p
+ AD=0.102p PS=1.28u PD=1.28u
M$50 GND|gnd IN|OUT$2 IN|OUT$3 GND|gnd sg13_hv_nmos L=0.45u W=0.3u AS=0.102p
+ AD=0.102p PS=1.28u PD=1.28u
M$51 GND|gnd \$148 \$149 GND|gnd sg13_hv_nmos L=0.45u W=0.3u AS=0.102p
+ AD=0.102p PS=1.28u PD=1.28u
M$52 GND|gnd IN|OUT$9 OUT$3 GND|gnd sg13_hv_nmos L=0.45u W=0.3u AS=0.102p
+ AD=0.102p PS=1.28u PD=1.28u
M$53 GND|gnd B$3 \$147 GND|gnd sg13_hv_nmos L=0.45u W=0.3u AS=0.102p AD=0.102p
+ PS=1.28u PD=1.28u
M$54 \$147 A$3 \$148 GND|gnd sg13_hv_nmos L=0.45u W=0.3u AS=0.102p AD=0.102p
+ PS=1.28u PD=1.28u
M$55 GND|gnd IN$3 IN|OUT$6 GND|gnd sg13_hv_nmos L=0.45u W=0.3u AS=0.102p
+ AD=0.102p PS=1.28u PD=1.28u
M$56 GND|gnd IN|OUT$6 IN|OUT$8 GND|gnd sg13_hv_nmos L=0.45u W=0.3u AS=0.102p
+ AD=0.102p PS=1.28u PD=1.28u
M$57 GND|gnd IN|OUT$8 IN|OUT$9 GND|gnd sg13_hv_nmos L=0.45u W=0.3u AS=0.102p
+ AD=0.102p PS=1.28u PD=1.28u
M$58 GND|gnd IN$4 IN|OUT$7 GND|gnd sg13_hv_nmos L=0.45u W=0.3u AS=0.102p
+ AD=0.102p PS=1.28u PD=1.28u
M$59 GND|gnd IN|OUT$7 IN|OUT$10 GND|gnd sg13_hv_nmos L=0.45u W=0.3u AS=0.102p
+ AD=0.102p PS=1.28u PD=1.28u
M$60 GND|gnd IN|OUT$10 IN|OUT$11 GND|gnd sg13_hv_nmos L=0.45u W=0.3u AS=0.102p
+ AD=0.102p PS=1.28u PD=1.28u
M$61 GND|gnd IN|OUT$11 OUT$4 GND|gnd sg13_hv_nmos L=0.45u W=0.3u AS=0.102p
+ AD=0.102p PS=1.28u PD=1.28u
M$62 VDD VDD VDD VDD sg13_hv_pmos L=0.4u W=4.5u AS=1.53p AD=1.53p PS=9.68u
+ PD=9.68u
M$63 OTA_VOP \$14 \$16 VDD sg13_hv_pmos L=1u W=4.5u AS=1.53p AD=1.53p PS=9.68u
+ PD=9.68u
M$64 \$16 \$34 OTA_VOM VDD sg13_hv_pmos L=1u W=4.5u AS=1.53p AD=1.53p PS=9.68u
+ PD=9.68u
M$65 VDD VDD VDD VDD sg13_hv_pmos L=0.4u W=4.5u AS=1.53p AD=1.53p PS=9.68u
+ PD=9.68u
M$66 \$24 VCM_REF \$3 VDD sg13_hv_pmos L=0.5u W=2.25u AS=0.765p AD=0.765p
+ PS=5.18u PD=5.18u
M$67 \$24 OTA_VOM \$17 VDD sg13_hv_pmos L=0.5u W=2.25u AS=0.765p AD=0.765p
+ PS=5.18u PD=5.18u
M$68 \$17 OTA_VOP \$24 VDD sg13_hv_pmos L=0.5u W=2.25u AS=0.765p AD=0.765p
+ PS=5.18u PD=5.18u
M$69 \$3 VCM_REF \$24 VDD sg13_hv_pmos L=0.5u W=2.25u AS=0.765p AD=0.765p
+ PS=5.18u PD=5.18u
M$70 VDD VDD VDD VDD sg13_hv_pmos L=0.4u W=4.5u AS=1.53p AD=1.53p PS=9.68u
+ PD=9.68u
M$71 OTA_VOM \$34 \$16 VDD sg13_hv_pmos L=1u W=4.5u AS=1.53p AD=1.53p PS=9.68u
+ PD=9.68u
M$72 \$16 \$14 OTA_VOP VDD sg13_hv_pmos L=1u W=4.5u AS=1.53p AD=1.53p PS=9.68u
+ PD=9.68u
M$73 VDD VDD VDD VDD sg13_hv_pmos L=0.4u W=4.5u AS=1.53p AD=1.53p PS=9.68u
+ PD=9.68u
M$74 VICM|VICM_REF \$34 \$34 VDD sg13_hv_pmos L=1u W=10u AS=3.4p AD=1.9p
+ PS=20.68u PD=10.38u
M$75 \$34 \$34 VICM|VICM_REF VDD sg13_hv_pmos L=1u W=10u AS=1.9p AD=1.9p
+ PS=10.38u PD=10.38u
M$76 VICM|VICM_REF \$34 \$34 VDD sg13_hv_pmos L=1u W=10u AS=1.9p AD=1.9p
+ PS=10.38u PD=10.38u
M$77 \$34 \$34 VICM|VICM_REF VDD sg13_hv_pmos L=1u W=10u AS=1.9p AD=1.9p
+ PS=10.38u PD=10.38u
M$78 VICM|VICM_REF \$34 \$34 VDD sg13_hv_pmos L=1u W=10u AS=1.9p AD=3.4p
+ PS=10.38u PD=20.68u
M$79 \$16 BV VDD VDD sg13_hv_pmos L=1u W=4u AS=1.36p AD=1.36p PS=8.68u PD=8.68u
M$80 \$16 BV VDD VDD sg13_hv_pmos L=1u W=4u AS=1.36p AD=1.36p PS=8.68u PD=8.68u
M$81 \$16 BV VDD VDD sg13_hv_pmos L=1u W=4u AS=1.36p AD=1.36p PS=8.68u PD=8.68u
M$82 \$16 BV VDD VDD sg13_hv_pmos L=1u W=4u AS=1.36p AD=1.36p PS=8.68u PD=8.68u
M$83 \$14 \$14 VICM|VICM_REF VDD sg13_hv_pmos L=1u W=10u AS=3.4p AD=1.9p
+ PS=20.68u PD=10.38u
M$84 VICM|VICM_REF \$14 \$14 VDD sg13_hv_pmos L=1u W=10u AS=1.9p AD=1.9p
+ PS=10.38u PD=10.38u
M$85 \$14 \$14 VICM|VICM_REF VDD sg13_hv_pmos L=1u W=10u AS=1.9p AD=1.9p
+ PS=10.38u PD=10.38u
M$86 VICM|VICM_REF \$14 \$14 VDD sg13_hv_pmos L=1u W=10u AS=1.9p AD=1.9p
+ PS=10.38u PD=10.38u
M$87 \$14 \$14 VICM|VICM_REF VDD sg13_hv_pmos L=1u W=10u AS=1.9p AD=3.4p
+ PS=10.38u PD=20.68u
M$88 out B \$101 \$102 sg13_hv_pmos L=1.8u W=1.2u AS=0.408p AD=0.408p PS=3.08u
+ PD=3.08u
M$89 \$101 A \$102 \$102 sg13_hv_pmos L=1.8u W=1.2u AS=0.408p AD=0.408p
+ PS=3.08u PD=3.08u
M$90 \$102 IN$1 IN|OUT \$102 sg13_hv_pmos L=0.9u W=0.6u AS=0.204p AD=0.204p
+ PS=1.88u PD=1.88u
M$91 BV BV VDD VDD sg13_hv_pmos L=1u W=4u AS=1.36p AD=1.36p PS=8.68u PD=8.68u
M$92 \$102 IN|OUT$5 OUT$1 \$102 sg13_hv_pmos L=0.9u W=0.6u AS=0.204p AD=0.204p
+ PS=1.88u PD=1.88u
M$93 \$102 B$1 \$104 \$102 sg13_hv_pmos L=0.45u W=0.3u AS=0.102p AD=0.102p
+ PS=1.28u PD=1.28u
M$94 \$104 A$1 \$102 \$102 sg13_hv_pmos L=0.45u W=0.3u AS=0.102p AD=0.102p
+ PS=1.28u PD=1.28u
M$95 \$102 \$104 \$105 \$102 sg13_hv_pmos L=0.9u W=0.6u AS=0.204p AD=0.204p
+ PS=1.88u PD=1.88u
M$96 \$24 BV VDD VDD sg13_hv_pmos L=1u W=4u AS=1.36p AD=1.36p PS=8.68u PD=8.68u
M$97 \$24 BV VDD VDD sg13_hv_pmos L=1u W=4u AS=1.36p AD=1.36p PS=8.68u PD=8.68u
M$98 \$24 BV VDD VDD sg13_hv_pmos L=1u W=4u AS=1.36p AD=1.36p PS=8.68u PD=8.68u
M$99 \$24 BV VDD VDD sg13_hv_pmos L=1u W=4u AS=1.36p AD=1.36p PS=8.68u PD=8.68u
M$100 \$102 IN|OUT$3 OUT \$102 sg13_hv_pmos L=0.9u W=0.6u AS=0.204p AD=0.204p
+ PS=1.88u PD=1.88u
M$101 \$102 IN|OUT IN|OUT$4 \$102 sg13_hv_pmos L=0.9u W=0.6u AS=0.204p
+ AD=0.204p PS=1.88u PD=1.88u
M$102 \$102 IN IN|OUT$1 \$102 sg13_hv_pmos L=0.9u W=0.6u AS=0.204p AD=0.204p
+ PS=1.88u PD=1.88u
M$103 \$102 IN|OUT$1 IN|OUT$2 \$102 sg13_hv_pmos L=0.9u W=0.6u AS=0.204p
+ AD=0.204p PS=1.88u PD=1.88u
M$104 \$102 IN|OUT$2 IN|OUT$3 \$102 sg13_hv_pmos L=0.9u W=0.6u AS=0.204p
+ AD=0.204p PS=1.88u PD=1.88u
M$105 \$102 IN|OUT$4 IN|OUT$5 \$102 sg13_hv_pmos L=0.9u W=0.6u AS=0.204p
+ AD=0.204p PS=1.88u PD=1.88u
M$106 OUT$2 IN$2 vdd vdd sg13_hv_pmos L=0.9u W=0.6u AS=0.204p AD=0.204p
+ PS=1.88u PD=1.88u
M$107 out$1 B$2 \$160 vdd sg13_hv_pmos L=1.8u W=1.2u AS=0.408p AD=0.408p
+ PS=3.08u PD=3.08u
M$108 \$160 A$2 vdd vdd sg13_hv_pmos L=1.8u W=1.2u AS=0.408p AD=0.408p PS=3.08u
+ PD=3.08u
M$109 vdd IN$3 IN|OUT$6 vdd sg13_hv_pmos L=0.9u W=0.6u AS=0.204p AD=0.204p
+ PS=1.88u PD=1.88u
M$110 vdd IN|OUT$9 OUT$3 vdd sg13_hv_pmos L=0.9u W=0.6u AS=0.204p AD=0.204p
+ PS=1.88u PD=1.88u
M$111 vdd B$3 \$148 vdd sg13_hv_pmos L=0.45u W=0.3u AS=0.102p AD=0.102p
+ PS=1.28u PD=1.28u
M$112 \$148 A$3 vdd vdd sg13_hv_pmos L=0.45u W=0.3u AS=0.102p AD=0.102p
+ PS=1.28u PD=1.28u
M$113 vdd \$148 \$149 vdd sg13_hv_pmos L=0.9u W=0.6u AS=0.204p AD=0.204p
+ PS=1.88u PD=1.88u
M$114 vdd IN|OUT$6 IN|OUT$8 vdd sg13_hv_pmos L=0.9u W=0.6u AS=0.204p AD=0.204p
+ PS=1.88u PD=1.88u
M$115 vdd IN|OUT$8 IN|OUT$9 vdd sg13_hv_pmos L=0.9u W=0.6u AS=0.204p AD=0.204p
+ PS=1.88u PD=1.88u
M$116 vdd IN$4 IN|OUT$7 vdd sg13_hv_pmos L=0.9u W=0.6u AS=0.204p AD=0.204p
+ PS=1.88u PD=1.88u
M$117 vdd IN|OUT$7 IN|OUT$10 vdd sg13_hv_pmos L=0.9u W=0.6u AS=0.204p AD=0.204p
+ PS=1.88u PD=1.88u
M$118 vdd IN|OUT$10 IN|OUT$11 vdd sg13_hv_pmos L=0.9u W=0.6u AS=0.204p
+ AD=0.204p PS=1.88u PD=1.88u
M$119 vdd IN|OUT$11 OUT$4 vdd sg13_hv_pmos L=0.9u W=0.6u AS=0.204p AD=0.204p
+ PS=1.88u PD=1.88u
C$120 \$57 \$50 cap_cmim w=26u l=12.8u A=332.8p P=77.6u m=1
C$121 IN|OUT$7 GND|gnd cap_cmim w=8u l=8u A=64p P=32u m=1
C$122 \$3 GND|gnd cap_cmim w=50u l=14u A=700p P=128u m=1
C$123 VOP GND|gnd cap_cmim w=98u l=98u A=9604p P=392u m=1
C$124 \$93 \$51 cap_cmim w=26u l=12.8u A=332.8p P=77.6u m=1
C$125 \$50 \$57 cap_cmim w=26u l=12.8u A=332.8p P=77.6u m=1
C$126 IN|OUT$1 GND|gnd cap_cmim w=8u l=8u A=64p P=32u m=1
C$127 VOM GND|gnd cap_cmim w=98u l=98u A=9604p P=392u m=1
C$128 \$52 \$55 cap_cmim w=5.7u l=5.7u A=32.49p P=22.8u m=1
C$129 \$55 \$52 cap_cmim w=5.7u l=5.7u A=32.49p P=22.8u m=1
C$130 IN|OUT$6 GND|gnd cap_cmim w=8u l=8u A=64p P=32u m=1
C$131 \$51 \$93 cap_cmim w=26u l=12.8u A=332.8p P=77.6u m=1
C$132 \$58 \$53 cap_cmim w=5.7u l=5.7u A=32.49p P=22.8u m=1
C$133 \$53 \$58 cap_cmim w=5.7u l=5.7u A=32.49p P=22.8u m=1
C$134 IN|OUT GND|gnd cap_cmim w=8u l=8u A=64p P=32u m=1
.ENDS digital_pulse_ina
